# Ansys Electronics Desktop project, version 2020.2

design Circuit1 (Circuit)
options: SParamCircuitDef IntegrationMethod=FFT
variables:
  Ct1 = 8.8pF  # tune 1pF..20pF
  Cm2 = 34.6pF
  Cm1 = 8.8pF
  Lm1 = 8.6nH  # optimise 1.95nH..5.85nH
  Cm3 = 22.4pF  # optimise 16.4pF..49.2pF
components:
  C1 = CAP_(C=Ct1)
  C2 = CAP_(C=Ct1)
  C3 = CAP_(C=Ct1)
  C4 = CAP_(C=Ct1)
  C5 = CAP_(C=Ct1)
  C6 = CAP_(C=Ct1)
  C7 = CAP_(C=Ct1)
  C9 = CAP_(C=Ct1)
  C10 = CAP_(C=Ct1)
  C11 = CAP_(C=Ct1)
  C12 = CAP_(C=Ct1)
  S225 = 16ch_loop1_curved_slim_w_lines_from_step_250_350MHz_SIE()  # Inactive_Open
  S229 = 16ch_loop1_curved_slim_from_step_V1_2p5mmres_sphere_280_320MHz_SIE()
  C86 = CAP_(C=Cm3)
  L87 = IND_(L=Lm1)
  S235 = 16ch_loop1_curved_all_gaps_V2_w_lines_from_step_250_350MHz_SIE()  # Inactive_Open
  port Port1 rz=50ohm iz=0ohm EnableNoise=false noisetemp=16.85cel
nets:
  0: C5.1, C3.1, C4.1, C12.1, C7.1, C10.1, C6.1, C11.1, C9.1, L87.1, C1.1, C2.1
  net_10: S229.6, C6.0
  net_11: S229.7, C7.0
  net_12: S229.9, C9.0
  net_13: S229.10, C10.0
  net_14: S229.11, C11.0
  net_15: S229.8, C12.0
  net_2: S229.0, C86.1
  net_5: S229.1, C1.0
  net_6: S229.2, C2.0
  net_7: S229.3, C3.0
  net_8: S229.4, C4.0
  net_9: C5.0, S229.5
  Port1: C86.0, L87.0
setups:
  LinearFrequency: LinearFrequencyData(false, 0.1, false, "", false) SweepDefinition{Variable=Freq Data="LIN 280MHz 320MHz 1MHz"}
optimetrics:
  OptimizationSetup1: Optimization UseFastCalculationUpdateAlgo Optimizer="Quasi Newton" AnalysisStopOptions{StopForNumIteration MaxNumIteration=1000 MinNumIteration=10} CostFuncNormType=L2 Acceptable_Cost=0 Noise=0.0001 UpdateDesignWhenDone
    vary Cm3: Min=1pF Max=100pF MinStep=0.01pF MaxStep=0.1pF MinFocus=16.4pF MaxFocus=49.2pF start=32.8pF
    vary Lm1: Min=1nH Max=100nH MinStep=0.01nH MaxStep=0.1nH MinFocus=1.95nH MaxFocus=5.85nH start=3.9nH
    goal dB(S(Port1,Port1)) <= -20 weight 1 on LinearFrequency : LinearFrequency at Freq 0.297GHz
reports:
  S Parameter Plot 1: dB(S(Port1,Port1)) vs Freq on LinearFrequency : LinearFrequency; markers MX1 at x=2.97e+08
  S Parameter Table 1: S(Port1,Port1) vs Freq on LinearFrequency : LinearFrequency
  S Parameter Table 2: dB(S(Port1,Port1)) vs Freq on LinearFrequency : LinearFrequency
